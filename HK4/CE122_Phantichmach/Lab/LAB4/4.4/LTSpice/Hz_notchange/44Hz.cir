* Netlist cho mạch đã cho
Vin in 0 AC 5
R1 in mid 510
L1 mid 0 1mH
RPOT3 mid out {rval}
C5 out 0 22uF

.param rval = 5k
.step param rval list 1 0.5k 1k 1.5k 2k 2.5k 3k 3.5k 4k 4.5k 5k
.op
.ac list 1200k

.end
